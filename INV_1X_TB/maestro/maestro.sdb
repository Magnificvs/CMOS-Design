ADE simulation setup
Run mode: Single Run, Sweeps and Corners
Tests:
  Demo_INV_1X_TB_1: Demo/INV_1X_TB/config, simulator spectre
