ADE simulation setup
Run mode: Single Run, Sweeps and Corners
Tests:
  Demo_NOR2_1X_TB_1: Demo/NOR2_1X_TB/schematic, simulator spectre
