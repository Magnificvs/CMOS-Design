ADE simulation setup
Test Inverter_INV_0_1: Demo/INV_0/schematic, simulator spectre
  Models: /home/viterbi/01/ee577/CDS_GPDK45/gpdk045_v_5_0/gpdk045/../models/spectre/gpdk045.scs[mc]
  Temperature: 27
  Stimulus in: voltage bit rise=10p fall=10p period=1n data=10101010
  Stimulus vdd!: voltage dc dc=1
  Analysis tran: stop=10n
  Signals: /in, /out
Run mode: Single Run, Sweeps and Corners
