ADE simulation setup
Run mode: Single Run, Sweeps and Corners
Tests:
  Inverter_INV_0_1: Demo/INV_0/schematic, simulator spectre
