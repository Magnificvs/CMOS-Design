ADE simulation setup
Run mode: Single Run, Sweeps and Corners
Tests:
  Demo_XOR_1X_1: Demo/XOR2_1X/schematic, simulator spectre
