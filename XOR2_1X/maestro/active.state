ADE simulation setup
Test Demo_XOR_1X_1: Demo/XOR2_1X/schematic, simulator spectre
  Models: /home/viterbi/01/ee577/CDS_GPDK45/gpdk045_v_5_0/gpdk045/../models/spectre/gpdk045.scs[mc]
  Temperature: 27
  Stimulus vdd!: voltage dc dc=1
  Stimulus A: voltage bit rise=10p fall=10p period=1n data=0011
  Stimulus B: voltage bit rise=10p fall=10p period=1n data=0110
  Analysis tran: stop=4n
  Signals: /A, /B, /OUT
Run mode: Single Run, Sweeps and Corners
