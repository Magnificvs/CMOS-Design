ADE simulation setup
Test Demo_INV_1X_1: Demo/INV_1X/av_extracted, simulator spectre
  Models: /home/viterbi/01/ee577/CDS_GPDK45/gpdk045_v_5_0/gpdk045/../models/spectre/gpdk045.scs[mc]
  Temperature: 27
  Stimulus vdd!: voltage dc dc=1
  Stimulus in: voltage bit rise=10p fall=10p period=1n data=1010101010
  Analysis tran: stop=10n
  Signals: /out, /in
Run mode: Single Run, Sweeps and Corners
