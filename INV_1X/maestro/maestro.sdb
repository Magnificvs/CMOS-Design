ADE simulation setup
Run mode: Single Run, Sweeps and Corners
Tests:
  Demo_INV_1X_1: Demo/INV_1X/av_extracted, simulator spectre
