ADE simulation setup
Test Demo_XOR2_1X_TB_1: Demo/XOR2_1X_TB/schematic, simulator spectre
  Models: /home/viterbi/01/ee577/CDS_GPDK45/gpdk045_v_5_0/gpdk045/../models/spectre/gpdk045.scs[mc]
  Temperature: 27
  Stimulus ina: voltage bit rise=10p fall=10p period=1n data=1100100111
  Stimulus inb: voltage bit rise=10p fall=10p period=1n data=1001110010
  Stimulus vdd!: voltage dc dc=1
  Analysis tran: stop=10n
  Signals: /ina1, /inb1, /out1
Run mode: Single Run, Sweeps and Corners
