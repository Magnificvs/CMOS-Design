ADE simulation setup
Run mode: Single Run, Sweeps and Corners
Tests:
  Demo_XOR2_1X_TB_1: Demo/XOR2_1X_TB/schematic, simulator spectre
