ADE simulation setup
Run mode: Single Run, Sweeps and Corners
Tests:
  Demo_1bit_adder_a_1: Demo/1bit_adder_tb/config, simulator spectre
