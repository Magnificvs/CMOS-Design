ADE simulation setup
Test Demo_4bit_adder_tb_1: Demo/4bit_adder_tb/schematic, simulator spectre
  Models: /home/viterbi/01/ee577/CDS_GPDK45/gpdk045_v_5_0/gpdk045/../models/spectre/gpdk045.scs[mc]
  Temperature: 27
  Stimulus A3: voltage bit rise=10p fall=10p period=1n data=0
  Stimulus A2: voltage bit rise=10p fall=10p period=1n data=0
  Stimulus A1: voltage bit rise=10p fall=10p period=1n data=0
  Stimulus A0: voltage bit rise=10p fall=10p period=1n data=0
  Stimulus B3: voltage bit rise=10p fall=10p period=1n data=1
  Stimulus B2: voltage bit rise=10p fall=10p period=1n data=1
  Stimulus B1: voltage bit rise=10p fall=10p period=1n data=1
  Stimulus B0: voltage bit rise=10p fall=10p period=1n data=1
  Stimulus C0: voltage bit rise=10p fall=10p period=1n data=101
  Stimulus vdd!: voltage dc dc=1
  Analysis tran: stop=3n
  Signals: /C0, /C4out
Run mode: Single Run, Sweeps and Corners
