ADE simulation setup
Run mode: Single Run, Sweeps and Corners
Tests:
  Demo_4bit_adder_tb_1: Demo/4bit_adder_tb/schematic, simulator spectre
