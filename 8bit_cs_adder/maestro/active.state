ADE simulation setup
Test Demo_8bit_cs_adder_1: Demo/8bit_cs_adder/schematic, simulator spectre
  Models: /home/viterbi/01/ee577/CDS_GPDK45/gpdk045_v_5_0/gpdk045/../models/spectre/gpdk045.scs[mc]
  Temperature: 27
  Files: vectors /home/viterbi/09/zhangx66/vector_file/file_with_time_step.vec
  Analysis tran: stop=10n
  Signals: /A7, /A6, /A5, /A4, /A3, /A2, /A1, /A0, /B7, /B6, /B5, /B4, /B3, /B2, /B1, /B0, /C0, /S7, /S6, /S5, /S4, /S3, /S2, /S1, /S0, /Cout
Run mode: Single Run, Sweeps and Corners
