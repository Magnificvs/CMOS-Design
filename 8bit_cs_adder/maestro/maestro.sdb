ADE simulation setup
Run mode: Single Run, Sweeps and Corners
Tests:
  Demo_8bit_cs_adder_1: Demo/8bit_cs_adder/schematic, simulator spectre
