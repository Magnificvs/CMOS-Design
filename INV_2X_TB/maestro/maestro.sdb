ADE simulation setup
Run mode: Single Run, Sweeps and Corners
Tests:
  Demo_inv_2x_tb_1: Demo/INV_2X_TB/config, simulator spectre
