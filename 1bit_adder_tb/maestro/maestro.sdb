ADE simulation setup
Run mode: Single Run, Sweeps and Corners
Tests:
  Demo_1bit_adder_tb_1: Demo/1bit_adder_tb/schematic, simulator spectre
