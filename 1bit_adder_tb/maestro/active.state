ADE simulation setup
Test Demo_1bit_adder_tb_1: Demo/1bit_adder_tb/schematic, simulator spectre
  Models: /home/viterbi/01/ee577/CDS_GPDK45/gpdk045_v_5_0/gpdk045/../models/spectre/gpdk045.scs[mc]
  Temperature: 27
  Stimulus A: voltage bit period=1n data=1
  Stimulus B: voltage bit period=1n data=0
  Stimulus Cin: voltage bit rise=10p fall=10p period=1n data=1010
  Stimulus vdd!: voltage dc dc=1
  Analysis tran: stop=4n
  Signals: /Cin, /Cout1
Run mode: Single Run, Sweeps and Corners
