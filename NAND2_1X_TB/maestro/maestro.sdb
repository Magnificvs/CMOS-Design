ADE simulation setup
Run mode: Single Run, Sweeps and Corners
Tests:
  Demo_NAND2_1X_TB_1: Demo/NAND2_1X_TB/schematic, simulator spectre
