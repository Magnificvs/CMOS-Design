ADE simulation setup
Test Demo_8bit_cs_adder_tb_1: Demo/8bit_cs_adder_tb/schematic, simulator spectre
  Models: /home/viterbi/01/ee577/CDS_GPDK45/gpdk045_v_5_0/gpdk045/../models/spectre/gpdk045.scs[mc]
  Temperature: 27
  Files: vectors /home/viterbi/09/zhangx66/vector_file/file_with_time_step.vec
  Analysis tran: stop=10n
  Signals: /C0, /Cout
Run mode: Single Run, Sweeps and Corners
